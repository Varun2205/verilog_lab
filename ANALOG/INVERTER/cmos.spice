** sch_path: /home/Varun/Projects/inverter/new_inv/cmos.sch
**.subckt cmos Vin Vout
*.ipin Vin
*.opin Vout
XM1 Vout Vin net1 net1 sky130_fd_pr__pfet_01v8 L=0.15 W=1 nf=1 ad='int((nf+1)/2)*W/nf*0.29' as='int((nf+2)/2)*W/nf*0.29'
+ pd='2*int((nf+1)/2)*(W/nf+0.29)' ps='2*int((nf+2)/2)*(W/nf+0.29)' nrd='0.29/W' nrs='0.29/W' sa=0 sb=0
+ sd=0 mult=1 m=1
XM2 Vout Vin GND GND sky130_fd_pr__nfet_01v8 L=0.15 W=1 nf=1 ad='int((nf+1)/2)*W/nf*0.29' as='int((nf+2)/2)*W/nf*0.29'
+ pd='2*int((nf+1)/2)*(W/nf+0.29)' ps='2*int((nf+2)/2)*(W/nf+0.29)' nrd='0.29/W' nrs='0.29/W' sa=0 sb=0
+ sd=0 mult=1 m=1
Vin Vin GND PULSE(0 1.8 0 1n 1n 1u 2u)
VDD net1 GND 1.8
C1 Vout GND 25p m=1
**** begin user architecture code

.option numparam
.lib $PDK_ROOT/sky130A/libs.tech/ngspice/sky130.lib.spice tt
.tran 1u 10u
.save all
.control
run
plot vin
plot vout
write cmos.raw
.endc
.end

?
**** end user architecture code
**.ends
.GLOBAL GND
.end
